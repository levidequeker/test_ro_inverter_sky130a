*TB_SUN_TR_SKY130NM/TB_NCM
*----------------------------------------------------------------
* Include
*----------------------------------------------------------------
#ifdef Lay
.include ../../../work/lpe/TB_gm_lpe.spi
#else
.include ../../../work/xsch/TB_gm.spice
#endif

*-----------------------------------------------------------------
* OPTIONS
*-----------------------------------------------------------------
.option TNOM=27 GMIN=1e-15 reltol=1e-3

*-----------------------------------------------------------------
* PARAMETERS
*-----------------------------------------------------------------
.param TRF = 10p

.param AVDD = {vdda}
.param Voffset = {AVDD/2}
.param Vamp = {AVDD*0.2}

*-----------------------------------------------------------------
* FORCE
*-----------------------------------------------------------------
VSS  VSS  0     dc 0
VDD  VDD  VSS  pwl 0 0 10n {AVDD}
VIN VIN VSS SIN({Voffset} {Vamp} 32768)
VOUT1 VOUT1 VSS pwl 0 0 10n {Voffset}
VOUT2 VOUT2 VSS pwl 0 0 10n {Voffset}
VOUT3 VOUT3 VSS pwl 0 0 10n {Voffset}
VOUT4 VOUT4 VSS pwl 0 0 10n {Voffset}
VOUT5 VOUT5 VSS pwl 0 0 10n {Voffset}

*-----------------------------------------------------------------
* DUT
*-----------------------------------------------------------------
.include ../xdut.spi

*----------------------------------------------------------------
* PROBE
*----------------------------------------------------------------
.save v(VIN) v(VOUT1) v(VDD) i(VOUT1) i(VOUT2) i(VOUT3) i(VOUT4) i(VOUT5)

*----------------------------------------------------------------
* NGSPICE control
*----------------------------------------------------------------
.control
set num_threads=8
set color0=white
set color1=black
unset askquit

optran 0 0 0 1n 1u 0

tran 200n 90u 1p
write
quit

.endc

.end
