*TB_SUN_TR_SKY130NM/TB_NCM
*----------------------------------------------------------------
* Include
*----------------------------------------------------------------
#ifdef Lay
.include ../../../work/lpe/TB_gm_AC_lpe.spi
#else
.include ../../../work/xsch/TB_gm_AC_NVT_LL.spice
#endif
.include current_vdd.spi
*.include sweep_params.spi
*-----------------------------------------------------------------
* OPTIONS
*-----------------------------------------------------------------
.option TNOM=27 GMIN=1e-15 reltol=1e-3 rshunt=1e12

*-----------------------------------------------------------------
* PARAMETERS
*-----------------------------------------------------------------
.param TRF = 10p
*.param AVDD = 0.1

*Scaled design 4
*.param m_alpha = 31
*.param m_I0 = 17
*.param m_beta = 15
*.param m_gamma = 20

*Benchmarked design 4
.param m_alpha = 18
.param m_I0 = 10
.param m_beta = 9
.param m_gamma = 12

*Scaled design 3
*.param m_alpha = 25
*.param m_I0 = 4
*.param m_beta = 3
*.param m_gamma = 8

*Benchmarked design 3
*.param m_alpha = 59
*.param m_I0 = 10
*.param m_beta = 7
*.param m_gamma = 18

*-----------------------------------------------------------------
* FORCE
*-----------------------------------------------------------------
VSS  VSS  0     dc 0
VDD  VDD  VSS   dc {AVDD}
VIN  VIN  VSS   dc {OP}  ac 1
VOUT VOUT VSS   dc {AVDD/2}

*-----------------------------------------------------------------
* DUT
*-----------------------------------------------------------------
.include ../xdut.spi

*----------------------------------------------------------------
* PROBE
*----------------------------------------------------------------
.save v(VIN) v(VOUT) i(VOUT)

*----------------------------------------------------------------
* NGSPICE control
*----------------------------------------------------------------
.control
set num_threads=8
set color0=white
set color1=black
unset askquit

ac dec 10 1 32768
write
quit

.endc

.end
