*TB_SUN_TR_SKY130NM/TB_NCM
*----------------------------------------------------------------
* Include
*----------------------------------------------------------------
#ifdef Lay
.include ../../../work/lpe/TB_FET_as_diode_lpe.spi
#else
.include ../../../work/xsch/TB_FET_as_diode.spice
#endif

*-----------------------------------------------------------------
* OPTIONS
*-----------------------------------------------------------------
.option TNOM=27 GMIN=1e-15 reltol=1e-3

*-----------------------------------------------------------------
* PARAMETERS
*-----------------------------------------------------------------
.param TRF = 10p

.param AVDD = {vdda}

*-----------------------------------------------------------------
* FORCE
*-----------------------------------------------------------------
VSS  VSS  0     dc 0
VDD  VDD  VSS  pwl 0 0 10n 0.2
VG VG VSS pwl 0 0 100u 0.2
IBIAS1 IBIAS1 VSS pwl 0 0 100u 10u
IBIAS2 IBIAS2 VSS pwl 0 0 100u 10u
IBIAS3 IBIAS3 VSS pwl 0 0 100u 10u
IBIAS4 IBIAS4 VSS pwl 0 0 100u 10u
IBIAS5 IBIAS5 VSS pwl 0 0 100u 10u
IBIAS6 IBIAS6 VSS pwl 0 0 100u 10u
IBIAS7 IBIAS7 VSS pwl 0 0 100u 10u
IBIAS8 IBIAS8 VSS pwl 0 0 100u 10u
IBIAS9 IBIAS9 VSS pwl 0 0 100u 10u
IBIAS10 IBIAS10 VSS pwl 0 0 100u 10u
IBIAS11 IBIAS11 VSS pwl 0 0 100u 10u
IBIAS12 IBIAS12 VSS pwl 0 0 100u 10u
IBIAS13 IBIAS13 VSS pwl 0 0 100u 10u
IBIAS14 IBIAS14 VSS pwl 0 0 100u 10u
IBIAS15 IBIAS15 VSS pwl 0 0 100u 10u
IBIAS16 IBIAS16 VSS pwl 0 0 100u 10u

*-----------------------------------------------------------------
* DUT
*-----------------------------------------------------------------
.include ../xdut.spi

*----------------------------------------------------------------
* PROBE
*----------------------------------------------------------------
.save all

*----------------------------------------------------------------
* NGSPICE control
*----------------------------------------------------------------
.control
set num_threads=8
set color0=white
set color1=black
unset askquit

optran 0 0 0 1n 1u 0

tran 10n 100u 1p
write
quit

.endc

.end
