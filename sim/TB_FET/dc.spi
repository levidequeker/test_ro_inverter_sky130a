*TB_SUN_TR_SKY130NM/TB_NCM

*----------------------------------------------------------------
* Include
*----------------------------------------------------------------

#ifdef Lay

.include ../../../work/lpe/TB_FET_lpe.spi

#else

.include ../../../work/xsch/TB_FET.spice

#endif

*-----------------------------------------------------------------
* OPTIONS
*-----------------------------------------------------------------

.option TNOM=27 GMIN=1e-15 reltol=1e-3

*-----------------------------------------------------------------
* PARAMETERS
*-----------------------------------------------------------------

.param TRF = 10p

*-----------------------------------------------------------------

* FORCE

*-----------------------------------------------------------------

VSS  VSS  0     dc 0

VDD  VDD  VSS dc 0.3

VG  VG VSS dc 0

*-----------------------------------------------------------------

* DUT

*-----------------------------------------------------------------

.include ../xdut.spi

*----------------------------------------------------------------

* PROBE

*----------------------------------------------------------------

.save all

*----------------------------------------------------------------

* NGSPICE control

*----------------------------------------------------------------

.control

set num_threads=8

set color0=white

set color1=black

unset askquit

dc VG 0 0.3 1m

write

quit

.endc

.end
