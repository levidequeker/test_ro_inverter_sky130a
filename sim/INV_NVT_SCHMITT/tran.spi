*TB_SUN_TR_SKY130NM/TB_NCM
*----------------------------------------------------------------
* Include
*----------------------------------------------------------------
#ifdef Lay
.include ../../../work/lpe/INV_NVT_SCHMITT_lpe.spi
#else
.include ../../../work/xsch/INV_NVT_SCHMITT.spice
#endif

*-----------------------------------------------------------------
* OPTIONS
*-----------------------------------------------------------------
.option TNOM=27 GMIN=1e-15 reltol=1e-3

*-----------------------------------------------------------------
* PARAMETERS
*-----------------------------------------------------------------
.param TRF = 10p

.param AVDD = 0.1
.param VOB = 0.05

*-----------------------------------------------------------------
* FORCE
*-----------------------------------------------------------------
VSS  VSS  0     dc 0
VDD  VDD  VSS  pwl 0 0 10n {AVDD}
VIN VIN VSS pwl 0 0 15u {AVDD} 30u 0
VOUT VOUT VSS pwl 0 0 10n {VOB}
*-----------------------------------------------------------------
* DUT
*-----------------------------------------------------------------
.include ../xdut.spi

*----------------------------------------------------------------
* PROBE
*----------------------------------------------------------------
.save v(vin) v(vout) i(vout) v(vdd) v(xdut.vn) v(xdut.vp) i(v.xdut.v1) i(v.xdut.v2) i(v.xdut.v3) i(v.xdut.v4) i(v.xdut.v5) i(v.xdut.v6)

*----------------------------------------------------------------
* NGSPICE control
*----------------------------------------------------------------
.control
set num_threads=8
set color0=white
set color1=black
unset askquit

optran 0 0 0 1n 1u 0

tran 100n 30u 1p
write
quit

.endc

.end
