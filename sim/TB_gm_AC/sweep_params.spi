* Autogenerated by Grid Search
.param m_alpha = 18
.param m_beta = 1
.param m_gamma = 1
