*TB_SUN_TR_SKY130NM/TB_NCM
*----------------------------------------------------------------
* Include
*----------------------------------------------------------------
#ifdef Lay
.include ../../../work/lpe/TB_gm_AC_lpe.spi
#else
.include ../../../work/xsch/TB_gm_AC.spice
#endif
*.include sweep_params.spi
*.include sweep_sizes.spi
.include current_vdd.spi
*-----------------------------------------------------------------
* OPTIONS
*-----------------------------------------------------------------
.option TNOM=27 GMIN=1e-15 reltol=1e-3 rshunt=1e12
.param m_alpha = 20
.param m_I0 = 3
.param m_beta = 2
.param m_gamma = 8
*-----------------------------------------------------------------
* PARAMETERS
*-----------------------------------------------------------------
.param TRF = 10p

*.param AVDD = 0.1

*-----------------------------------------------------------------
* FORCE
*-----------------------------------------------------------------
VSS  VSS  0     dc 0
VDD  VDD  VSS   dc {AVDD}
VIN  VIN  VSS   dc {OP}  ac 1
VOUT VOUT VSS   dc {AVDD/2}

*-----------------------------------------------------------------
* DUT
*-----------------------------------------------------------------
.include ../xdut.spi

*----------------------------------------------------------------
* PROBE
*----------------------------------------------------------------
.save v(VIN) v(VOUT) i(VOUT)

*----------------------------------------------------------------
* NGSPICE control
*----------------------------------------------------------------
.control
set num_threads=8
set color0=white
set color1=black
unset askquit

ac dec 10 1 32768
write
quit

.endc

.end
