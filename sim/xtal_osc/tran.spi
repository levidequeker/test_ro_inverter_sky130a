*TB_SUN_TR_SKY130NM/TB_NCM
*----------------------------------------------------------------
* Include
*----------------------------------------------------------------
#ifdef Lay
.include ../../../work/lpe/xtal_osc_lpe.spi
#else
.include ../../../work/xsch/xtal_osc_adapted.spice
#endif

*-----------------------------------------------------------------
* OPTIONS
*-----------------------------------------------------------------
.option TNOM=27 GMIN=1e-15 reltol=1e-5

*-----------------------------------------------------------------
* PARAMETERS
*-----------------------------------------------------------------
.param TRF = 10p

*Scaled design
*.param AVDD = {vdda}
*.param m_alpha = 20
*.param m_beta = 2
*.param m_gamma = 8
*.param m_I0 = 3

* Benchmark design
.param AVDD = {vdda}
.param m_alpha = 62
.param m_beta = 5
.param m_gamma = 24
.param m_I0 = 10
*-----------------------------------------------------------------
* FORCE
*-----------------------------------------------------------------
VSS  VSS  0     dc 0
VDD  VDD  VSS  pwl 0 0 100n {AVDD}
*-----------------------------------------------------------------
* DUT
*-----------------------------------------------------------------
.include ../xdut.spi

*----------------------------------------------------------------
* PROBE
*----------------------------------------------------------------
.save all

*----------------------------------------------------------------
* NGSPICE control
*----------------------------------------------------------------
.control
set num_threads=8
set color0=white
set color1=black
unset askquit

optran 0 0 0 1n 1u 0

tran 300n 250m 0 1u uic
write
quit

.endc
.end
