*TB_SUN_TR_SKY130NM/TB_NCM
*----------------------------------------------------------------
* Include
*----------------------------------------------------------------
#ifdef Lay
.include ../../../work/lpe/TB_Cout_lpe.spi
#else
.include ../../../work/xsch/TB_Cout.spice
#endif
.include current_vdd.spi
*-----------------------------------------------------------------
* OPTIONS
*-----------------------------------------------------------------
.option TNOM=27 GMIN=1e-15 reltol=1e-3 rshunt=1e12

*-----------------------------------------------------------------
* PARAMETERS
*-----------------------------------------------------------------
.param TRF = 10p

*Scaled design
*.param m_alpha = 20
*.param m_I0 = 3
*.param m_beta = 2
*.param m_gamma = 8

*Benchmarked design
.param m_alpha = 62
.param m_I0 = 10
.param m_beta = 5
.param m_gamma = 24
*-----------------------------------------------------------------
* FORCE
*-----------------------------------------------------------------
VSS  VSS  0     dc 0
VDD  VDD  VSS dc 0
VIN VIN VSS dc 0
VOUT VOUT VSS dc 0

VSS_TRAN  VSS_TRAN  0     dc 0
VDD_TRAN  VDD_TRAN  VSS_TRAN  pwl 0 0 10n {AVDD}
VIN_TRAN VIN_TRAN VSS_TRAN sin({AVDD/2} {AVDD/2} 32768
*sin({AVDD/2} {AVDD/2} 32768)
*pwl 0 0 971n {AVDD} 1942n 0
*VOUT_TRAN VOUT_TRAN VSS_TRAN dc {AVDD/2}

*-----------------------------------------------------------------
* DUT
*-----------------------------------------------------------------
.include ../xdut.spi

*----------------------------------------------------------------
* PROBE
*----------------------------------------------------------------
.save v(vin_tran) i(vout_tran) v(vout_tran)

*----------------------------------------------------------------
* NGSPICE control
*----------------------------------------------------------------
.control
set num_threads=8
set color0=white
set color1=black
unset askquit

optran 0 0 0 1n 1u 0

tran 10n 90u 1p
write
quit

.endc

.end
